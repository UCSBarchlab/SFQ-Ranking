// Design: Ranking_Rebuttal/fo3_wranking_fig8
simulator lang=spectre
global 0
parameters VCC=2.6m
include "<path/to/model/files>"

// MITLL_SFQ/jjsh/schematic
subckt jjsh B T
parameters jjsh_rl=700n jjsh_rw=500n jjsh_rsh=2.0 jjsh_d=700n
    R0 (T B) res_r5 l=jjsh_rl w=jjsh_rw rsh=jjsh_rsh
    J0 (T B) model_jj ic_v=0 ic_phase=0 mfactor=1 d=jjsh_d
ends jjsh

// Ranking_Rebuttal/dcsfq_suny1/schematic
subckt dcsfq_suny1 IN OUT VCC
    I3 (0 net12) jjsh jjsh_rl=700n jjsh_rw=550n jjsh_rsh=2.0 jjsh_d=1.8u
    I2 (0 net9) jjsh jjsh_rl=950n jjsh_rw=500n jjsh_rsh=2.0 jjsh_d=1.5u
    I1 (net10 net14) jjsh jjsh_rl=900n jjsh_rw=500n jjsh_rsh=2.0 jjsh_d=1.5u
    I0 (net13 net7) jjsh jjsh_rl=1u jjsh_rw=500n jjsh_rsh=2.0 jjsh_d=1.4u
    R0 (VCC net11) res_r5 l=1.75u w=500n rsh=2.0
    L8 (net12 OUT) inductor l=2.11p
    L7 (net11 net12) inductor l=1.74p
    L6 (net13 net9) inductor l=690.00f
    L5 (net10 net9) inductor l=210.00f
    L4 (net7 0) inductor l=3.59p
    L3 (net8 net7) inductor l=1.27p
    L2 (net10 net11) inductor l=1.14p
    L1 (net8 net14) inductor l=1.29p
    L0 (IN net8) inductor l=3.35p
ends dcsfq_suny1

// Ranking_Rebuttal/jtl_250uA/schematic
subckt jtl_250uA IN OUT VCC
    L3 (net9 OUT) inductor l=1p
    L2 (net8 net9) inductor l=1p
    L1 (net7 net8) inductor l=1p
    L0 (IN net7) inductor l=1p
    I1 (0 net9) jjsh jjsh_rl=700n jjsh_rw=550n jjsh_rsh=2.0 jjsh_d=1.8u
    I0 (0 net7) jjsh jjsh_rl=700n jjsh_rw=550n jjsh_rsh=2.0 jjsh_d=1.8u
    R0 (VCC net8) res_r5 l=1.85u w=500n rsh=2.0
ends jtl_250uA

// Ranking_Rebuttal/jtl_250to353uA/schematic
subckt jtl_250to353uA IN OUT VCC
    L3 (net9 OUT) inductor l=700.0f
    L2 (net8 net9) inductor l=700.0f
    L1 (net7 net8) inductor l=1p
    L0 (IN net7) inductor l=1p
    I1 (0 net9) jjsh jjsh_rl=700n jjsh_rw=800n jjsh_rsh=2.0 jjsh_d=2.15u
    I0 (0 net7) jjsh jjsh_rl=700n jjsh_rw=550n jjsh_rsh=2.0 jjsh_d=1.8u
    R0 (VCC net8) res_r5 l=1.55u w=500n rsh=2.0
ends jtl_250to353uA

// Ranking_Rebuttal/jtl_353to500uA/schematic
subckt jtl_353to500uA IN OUT VCC
    L3 (net9 OUT) inductor l=700.0f
    L2 (net8 net9) inductor l=700.0f
    L1 (net7 net8) inductor l=1p
    L0 (IN net7) inductor l=1p
    I1 (0 net9) jjsh jjsh_rl=700n jjsh_rw=1.15u jjsh_rsh=2.0 jjsh_d=2.55u
    I0 (0 net7) jjsh jjsh_rl=700n jjsh_rw=800n jjsh_rsh=2.0 jjsh_d=2.15u
    R0 (VCC net8) res_r5 l=1.1u w=500n rsh=2.0
ends jtl_353to500uA

// Ranking_Rebuttal/fo3_wranking_fig8/schematic
I0 (0 net6) isource type=pulse val0=0 val1=500.0u period=250p delay=50p rise=20p fall=20p width=10p
V1 (net037 0) vsource type=pwl wave=[ 0 0 1p VCC ]
V0 (net5 0) vsource type=pwl wave=[ 0 0 1p 2.6m ]
I36 (net6 net7 net5) dcsfq_suny1
I37 (net7 IN net037) jtl_250uA
I42 (net025 OUT1 net037) jtl_250uA
I45 (OUT net023 net037) jtl_250uA
I38 (IN net027 net037) jtl_250uA
I39 (net027 net028 net037) jtl_250uA
I43 (OUT1 net022 net037) jtl_250uA
I47 (OUT2 net021 net037) jtl_250uA
I40 (net028 net029 net037) jtl_250uA
I41 (OUT net025 net037) jtl_250uA
I44 (net022 net019 net037) jtl_250uA
I48 (net021 net018 net037) jtl_250uA
I46 (net023 OUT2 net037) jtl_250uA
I49 (OUT net024 net037) jtl_250uA
I50 (net024 OUT3 net037) jtl_250uA
I51 (OUT3 net020 net037) jtl_250uA
I52 (net020 net017 net037) jtl_250uA
I53 (net029 net030 net037) jtl_250to353uA
I54 (net030 OUT net037) jtl_353to500uA
simulatorOptions options temp=27
tran tran stop=800p start=0 step=0.1p maxstep=0.5p minstep=0.05p
