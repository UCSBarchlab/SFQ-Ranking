// Design: Ranking_Rebuttal/fo9_wranking_fig10
simulator lang=spectre
global 0
parameters VCC=2.6m
include "<path/to/model/files>"

// MITLL_SFQ/jjsh/schematic
subckt jjsh B T
parameters jjsh_rl=700n jjsh_rw=500n jjsh_rsh=2.0 jjsh_d=700n
    R0 (T B) res_r5 l=jjsh_rl w=jjsh_rw rsh=jjsh_rsh
    J0 (T B) model_jj ic_v=0 ic_phase=0 mfactor=1 d=jjsh_d
ends jjsh

// Ranking_Rebuttal/dcsfq_suny1/schematic
subckt dcsfq_suny1 IN OUT VCC
    I3 (0 net12) jjsh jjsh_rl=700n jjsh_rw=550n jjsh_rsh=2.0 jjsh_d=1.8u
    I2 (0 net9) jjsh jjsh_rl=950n jjsh_rw=500n jjsh_rsh=2.0 jjsh_d=1.5u
    I1 (net10 net14) jjsh jjsh_rl=900n jjsh_rw=500n jjsh_rsh=2.0 jjsh_d=1.5u
    I0 (net13 net7) jjsh jjsh_rl=1u jjsh_rw=500n jjsh_rsh=2.0 jjsh_d=1.4u
    R0 (VCC net11) res_r5 l=1.75u w=500n rsh=2.0
    L8 (net12 OUT) inductor l=2.11p
    L7 (net11 net12) inductor l=1.74p
    L6 (net13 net9) inductor l=690.00f
    L5 (net10 net9) inductor l=210.00f
    L4 (net7 0) inductor l=3.59p
    L3 (net8 net7) inductor l=1.27p
    L2 (net10 net11) inductor l=1.14p
    L1 (net8 net14) inductor l=1.29p
    L0 (IN net8) inductor l=3.35p
ends dcsfq_suny1

// Ranking_Rebuttal/jtl_500uA/schematic
subckt jtl_500uA IN OUT VCC
    L3 (net9 OUT) inductor l=500.0f
    L2 (net8 net9) inductor l=500.0f
    L1 (net7 net8) inductor l=500.0f
    L0 (IN net7) inductor l=500.0f
    I1 (0 net9) jjsh jjsh_rl=700n jjsh_rw=1.15u jjsh_rsh=2.0 jjsh_d=2.55u
    I0 (0 net7) jjsh jjsh_rl=700n jjsh_rw=1.15u jjsh_rsh=2.0 jjsh_d=2.55u
    R0 (VCC net8) res_r5 l=950n w=500n rsh=2.0
ends jtl_500uA

// Ranking_Rebuttal/jtl_250uA/schematic
subckt jtl_250uA IN OUT VCC
    L3 (net9 OUT) inductor l=1p
    L2 (net8 net9) inductor l=1p
    L1 (net7 net8) inductor l=1p
    L0 (IN net7) inductor l=1p
    I1 (0 net9) jjsh jjsh_rl=700n jjsh_rw=550n jjsh_rsh=2.0 jjsh_d=1.8u
    I0 (0 net7) jjsh jjsh_rl=700n jjsh_rw=550n jjsh_rsh=2.0 jjsh_d=1.8u
    R0 (VCC net8) res_r5 l=1.85u w=500n rsh=2.0
ends jtl_250uA

// Ranking_Rebuttal/jtl_250to353uA/schematic
subckt jtl_250to353uA IN OUT VCC
    L3 (net9 OUT) inductor l=700.0f
    L2 (net8 net9) inductor l=700.0f
    L1 (net7 net8) inductor l=1p
    L0 (IN net7) inductor l=1p
    I1 (0 net9) jjsh jjsh_rl=700n jjsh_rw=800n jjsh_rsh=2.0 jjsh_d=2.15u
    I0 (0 net7) jjsh jjsh_rl=700n jjsh_rw=550n jjsh_rsh=2.0 jjsh_d=1.8u
    R0 (VCC net8) res_r5 l=1.55u w=500n rsh=2.0
ends jtl_250to353uA

// Ranking_Rebuttal/jtl_353to500uA/schematic
subckt jtl_353to500uA IN OUT VCC
    L3 (net9 OUT) inductor l=700.0f
    L2 (net8 net9) inductor l=700.0f
    L1 (net7 net8) inductor l=1p
    L0 (IN net7) inductor l=1p
    I1 (0 net9) jjsh jjsh_rl=700n jjsh_rw=1.15u jjsh_rsh=2.0 jjsh_d=2.55u
    I0 (0 net7) jjsh jjsh_rl=700n jjsh_rw=800n jjsh_rsh=2.0 jjsh_d=2.15u
    R0 (VCC net8) res_r5 l=1.1u w=500n rsh=2.0
ends jtl_353to500uA

// Ranking_Rebuttal/fo9_wranking_fig10/schematic
I0 (0 net6) isource type=pulse val0=0 val1=500.0u period=100p delay=50p rise=20p fall=20p width=10p
V1 (net037 0) vsource type=pwl wave=[ 0 0 1p VCC ]
V0 (net5 0) vsource type=pwl wave=[ 0 0 1p 2.6m ]
I36 (net6 net7 net5) dcsfq_suny1
I96 (net091 net043 net037) jtl_500uA
I95 (OUT1 net091 net037) jtl_500uA
I94 (net089 net0102 net037) jtl_500uA
I93 (net064 net089 net037) jtl_500uA
I92 (net097 net094 net037) jtl_500uA
I91 (net063 net097 net037) jtl_500uA
I90 (net092 net0100 net037) jtl_500uA
I89 (net065 net092 net037) jtl_500uA
I88 (net099 net095 net037) jtl_500uA
I87 (net067 net099 net037) jtl_500uA
I86 (net0101 net093 net037) jtl_500uA
I85 (net068 net0101 net037) jtl_500uA
I84 (net087 net046 net037) jtl_500uA
I83 (net066 net087 net037) jtl_500uA
I82 (net096 net045 net037) jtl_500uA
I81 (net070 net096 net037) jtl_500uA
I80 (net088 net044 net037) jtl_500uA
I79 (net069 net088 net037) jtl_500uA
I37 (net7 IN net037) jtl_250uA
I38 (IN net027 net037) jtl_250uA
I39 (net027 net028 net037) jtl_250uA
I40 (net028 net029 net037) jtl_250uA
I78 (net019 net049 net037) jtl_250to353uA
I76 (net019 net047 net037) jtl_250to353uA
I75 (net019 net048 net037) jtl_250to353uA
I70 (net072 net061 net037) jtl_250to353uA
I69 (net072 net062 net037) jtl_250to353uA
I67 (net072 net060 net037) jtl_250to353uA
I66 (net018 net058 net037) jtl_250to353uA
I56 (OUT net016 net037) jtl_250to353uA
I63 (net018 net051 net037) jtl_250to353uA
I64 (net018 net050 net037) jtl_250to353uA
I59 (OUT net056 net037) jtl_250to353uA
I58 (OUT net057 net037) jtl_250to353uA
I53 (net029 net030 net037) jtl_250to353uA
I77 (net047 net063 net037) jtl_353to500uA
I74 (net048 net064 net037) jtl_353to500uA
I73 (net049 net065 net037) jtl_353to500uA
I72 (net060 net066 net037) jtl_353to500uA
I71 (net061 net067 net037) jtl_353to500uA
I68 (net062 net068 net037) jtl_353to500uA
I65 (net050 net069 net037) jtl_353to500uA
I57 (net057 net072 net037) jtl_353to500uA
I62 (net051 net070 net037) jtl_353to500uA
I61 (net058 OUT1 net037) jtl_353to500uA
I55 (net016 net018 net037) jtl_353to500uA
I60 (net056 net019 net037) jtl_353to500uA
I54 (net030 OUT net037) jtl_353to500uA
simulatorOptions options temp=27
tran tran stop=1600p start=0 step=0.1p maxstep=0.5p minstep=0.05p
